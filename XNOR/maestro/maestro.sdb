ADE simulation setup
Run mode: Single Run, Sweeps and Corners
Tests:
  ECE555_XNOR_1: ECE555/XNOR/schematic, simulator hspiceD
