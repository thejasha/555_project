ADE simulation setup
Test ECE555_XNOR_1: ECE555/XNOR/schematic, simulator hspiceD
